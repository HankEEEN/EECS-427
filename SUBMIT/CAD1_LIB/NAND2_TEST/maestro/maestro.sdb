ADE simulation setup
Run mode: Single Run, Sweeps and Corners
Tests:
  CAD1_LIB_NAND2_TEST_1: CAD1_LIB/NAND2_TEST/schematic, simulator hspiceD
    Variables: outcap = 25f
