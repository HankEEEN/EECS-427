ADE simulation setup
Run mode: Single Run, Sweeps and Corners
Tests:
  CAD1_LIB_MUX21_TEST_1: CAD1_LIB/MUX21_TEST/schematic, simulator hspiceD
    Variables: outcap = 25f
