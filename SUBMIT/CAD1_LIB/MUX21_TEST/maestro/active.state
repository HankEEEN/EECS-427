ADE simulation setup
Test CAD1_LIB_MUX21_TEST_1: CAD1_LIB/MUX21_TEST/schematic, simulator hspiceD
  Models: /afs/umich.edu/class/eecs427/ibm13/cmrf8sf/relLM/HSPICE/models/allModels.inc[tt], /afs/umich.edu/class/eecs427/ibm13/cmrf8sf/relLM/HSPICE/models/design.inc
  Variables: outcap = 25f
  Stimulus IN0: voltage pulse v1=0 v2=1.2 per=16n td=4n tr=100p tf=100p pw=8n
  Stimulus IN1: voltage pulse v1=0 v2=1.2 per=16n td=8.2n tr=100p tf=100p pw=8n
  Stimulus SEL: voltage pulse v1=0 v2=1.2 per=9n tr=100p tf=100p pw=4.5n
  Stimulus VDD!: voltage dc vdc=1.2
  Stimulus VSS!: voltage dc vdc=0
  Analysis tran: start=0 stop=20n step=100p
  Signals: /IN0, /IN1, /SEL, /OUT
Run mode: Single Run, Sweeps and Corners
