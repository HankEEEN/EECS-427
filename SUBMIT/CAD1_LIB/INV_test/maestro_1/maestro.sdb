ADE simulation setup
Run mode: Single Run, Sweeps and Corners
Tests:
  CAD1_LIB_INV_test_1: CAD1_LIB/INV_test/schematic, simulator hspiceD
    Variables: outcap = 25f
