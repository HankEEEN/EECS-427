ADE simulation setup
Test CAD1_LIB_INV_test_1: CAD1_LIB/INV_test/schematic, simulator hspiceD
  Models: /afs/umich.edu/class/eecs427/ibm13/cmrf8sf/relLM/HSPICE/models/allModels.inc[tt], /afs/umich.edu/class/eecs427/ibm13/cmrf8sf/relLM/HSPICE/models/design.inc
  Variables: outcap = 25f
  Stimulus IN: voltage pulse v1=0 v2=1.2 per=4n td=1n tr=100p tf=100p pw=2n
  Stimulus VDD!: voltage dc vdc=1.2
  Stimulus VSS!: voltage dc vdc=0
  Analysis tran: start=0 stop=10n step=100p
  Signals: /IN, /OUT
Run mode: Single Run, Sweeps and Corners
